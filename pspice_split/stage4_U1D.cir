* ===== 4단계: U1D 만 시뮬레이션 (체험판 노드 수 제한 회피용) =====
* - 인입: N2 (+입력, VIN 6V)
* - 기준: REF4 = 2.4V (-입력)
* - 예상: VIN(6V) > 2.4V -> D4 ON
* ---- 전원 ----
V1 VCC 0 DC 12
V2 VIN 0 DC 6

* ---- 스위치 U2 (Sw_tClose 대체: t=1ms 에서 닫힘) ----
VCTL CTL 0 PWL(0 0 1m 0 1.001m 1)
SU2  VIN N2 CTL 0 SWCLOSE
.model SWCLOSE VSWITCH(Ron=0.01 Roff=1Meg Von=1 Voff=0)

* ---- 비교 기준 전압 분배기 (5개 저항 모두 유지 -> 기준전압 동일) ----
R9 VCC REF1 1k
R1 REF1 REF2 1k
R2 REF2 REF3 1k
R3 REF3 REF4 1k
R4 REF4 0    1k

* ---- + 입력 공통선의 커패시터 (모두 N2 에 병렬, 노드 추가 없음) ----
C1 N2 0 100u
C2 N2 0 100u
C3 N2 0 100u
C4 N2 0 100u

* ---- LED 대신 쓰인 Dbreak 모델 ----
.model Dbreak D(Is=1e-14 Rs=0.1 Cjo=0.1p)

* ---- 이번 단계의 비교기 ----
XU1D N2 REF4 VCC 0 OUT14 LM324
R8 OUT14 OUT14_A 330
D4 OUT14_A 0 Dbreak

* ---- LM324 macromodel (PSpice eval.lib 동일 구조) ----
* 핀 순서: +입력  -입력  V+  V-  출력
.subckt LM324 1 2 3 4 5
c1   11 12 5.544E-12
c2    6  7 20.00E-12
dc    5 53 dx
de   54  5 dx
dlp  90 91 dx
dln  92 90 dx
dp    4  3 dx
egnd 99  0 poly(2) (3,0) (4,0) 0 .5 .5
fb    7 99 poly(5) vb vc ve vlp vln 0 15.91E6 -20E6 20E6 20E6 -20E6
ga    6  0 11 12 125.7E-6
gcm   0  6 10 99 7.067E-9
iee   3 10 dc 10.04E-6
hlim 90  0 vlim 1K
q1   11  2 13 qx
q2   12  1 14 qx
r2    6  9 100.0E3
rc1   4 11 7.957E3
rc2   4 12 7.957E3
re1  13 10 2.773E3
re2  14 10 2.773E3
ree  10 99 19.92E6
ro1   8  5 50
ro2   7 99 50
rp    3  4 30.31E3
vb    9  0 dc 0
vc    3 53 dc 2.100
ve   54  4 dc .6
vlim  7  8 dc 0
vlp  91  0 dc 40
vln   0 92 dc 40
.model dx D(Is=800.0E-18)
.model qx PNP(Is=800.0E-18 Bf=166.7)
.ends LM324

.TRAN 10u 10m
.PROBE
.PRINT TRAN V(N2) V(REF4) V(OUT14) I(R8)
.END
